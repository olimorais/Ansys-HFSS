# Ansys Electronics Desktop project, version 2022.2
materials:
  vacuum: permittivity=1
  perfect conductor: conductivity=1e+30
  copper: permeability=0.999991 conductivity=58000000
  Rogers RO4350 (tm): permittivity=3.66 dielectric_loss_tangent=0.004
  air: permittivity=1.0006 permeability=1.0000004

design HFSSDesign1 (HFSS, DrivenModal, model units in)
notes: PCB with Microstrip Trace and Connector Footprint
PCB.hfss

Date: December 2013
Created By: ANSYS Technical Support

Decription:
===================================================
HFSS starting point project for Coax to Microstrip Transition
design.  The user will add a connector from the 3D component library, construct the solution air box, add port excitations, add solution setup, analyze, and create plots for the results.

Substrate: RO4350(tm)
                     er = 3.66
                     tand = 0.004
                     size: 1 in x 1.5 in x 0.030 in

Trace:        50 Ohm Microstrip Trace
                     trace thickness: 0.7 mil (1/2 oz Cu)
     
Footprint:   Edge Mount SMA Connector
                     SMA_edge_connector.a3dcomp
options: Save_Adaptive_support_files Notes="PCB with Microstrip Trace and Connector Footprint / PCB.hfss / Date: December 2013 / Created By: ANSYS Technical Support / Decription: / =================================================== / HFSS starting point project for Coax to Microstrip Transition / design.  The user will add a connector from the 3D component library, construct the solution air box, add port excitations, add solution setup, analyze, and create plots for the results. / Substrate: RO4350(tm) / er = 3.66 / tand = 0.004 / size: 1 in x 1.5 in x 0.030 in / Trace:        50 Ohm Microstrip Trace / trace thickness: 0.7 mil (1/2 oz Cu) / Footprint:   Edge Mount SMA Connector / SMA_edge_connector.a3dcomp"
variables:
  cpw_width = 0.047in  # tune 0.04in..0.06in
  trace_thickness = 0.7mil
geometry:
  substrate [Rogers RO4350 (tm)] = polyline((0in, 0in, 0in) (-1in, 0in, 0in), section rectangle width=1.5in height=0in)
  substrate.sweep_along_vector((0in, 0in, -0.03in))
  trace [copper] = polyline((0in, 0in, trace_thickness/2) (-1in, 0in, trace_thickness/2), section rectangle width=0.066in height=trace_thickness)
  coordinate_system RelativeCS1 = origin=(-0.15in, 0in, 0in) x=(1in, 0in, 0in) y=(0in, 1in, 0in)
  trace.split(plane=YZ, keep=NegativeOnly) in RelativeCS1
  gnd_pad_right = rectangle(corner=(0in, 0.093110236in, 0in), x_size=-0.15in, y_size=0.08in)
  gnd_vias_right = cylinder(axis=Z, base_centre=(0in, 0.10905512in, 0in), radius=0.01in, height=-0.03in)
  gnd_vias_right.move(-0.02in, 0.04in, 0in)
  Cylinder2_1, Cylinder2_2 = gnd_vias_right.duplicate_along_line(step=(-0.05in, 0in, 0in), total=3)
  Cylinder2_2_1 = Cylinder2_2.duplicate_mirror(point=(0in, 0in, 0in), normal=(0in, -1in, 0in))
  Cylinder2_1_1 = Cylinder2_1.duplicate_mirror(point=(0in, 0in, 0in), normal=(0in, -1in, 0in))
  gnd_vias_left [perfect conductor] = gnd_vias_right.duplicate_mirror(point=(0in, 0in, 0in), normal=(0in, -1in, 0in))
  gnd_pad_left = gnd_pad_right.duplicate_mirror(point=(0in, 0in, 0in), normal=(0in, -1in, 0in))
  Polyline4 = polyline((0in, 0in, 0in) (-0.15in, 0in, 0in), section rectangle width=cpw_width height=0in)
  Polyline4.sweep_along_vector((0in, 0in, trace_thickness))
  trace.unite(Polyline4)
  gnd_vias_left.unite(Cylinder2_1_1, Cylinder2_2_1)
  gnd_vias_right.unite(Cylinder2_1, Cylinder2_2)
  Port_Wave [air] = rectangle(corner=(-1in, 0.33in, -0.03in), y_size=-0.66in, z_size=0.3in)
  Region [vacuum] = region(+X=0 percentage offset, -X=0 percentage offset, +Y=0 percentage offset, -Y=0 percentage offset, +Z=0.59in absolute offset, -Z=0.25in absolute offset)
  SMA_edge_connector_half1 = component(HFSSDesign1, 3D_Component_File_Path="D:/Rodrigo_ESSS/Temp_Shared/Curso HFSS/Gravacoes_Raw/WS 1.2/SMA_edge_connector_half.a3dcomp", trace_thickness=0.7mil, gnd_pin_length=0.15in, pin_dia=0.03in, pin_length=0.15in, pcb_thickness=0.03in)
  conn_center_pin [perfect conductor] = part_of(SMA_edge_connector_half1)
  conn_diel [Teflon (tm) lossless] = part_of(SMA_edge_connector_half1)
  conn_shell [perfect conductor] = part_of(SMA_edge_connector_half1)
  [gnd_vias_left, gnd_vias_right].split(plane=ZX, keep=NegativeOnly)
  gnd_vias_right.delete()
  [trace, substrate, gnd_pad_left, gnd_pad_right].split(plane=ZX, keep=NegativeOnly)
  gnd_pad_right.delete()
  Port_Wave.split(plane=ZX, keep=NegativeOnly)
  SMA_edge_connector6 = component(HFSSDesign2, 3D_Component_File_Path="C:/Users/Ana/Desktop/Ufop/Curso HFSS/Arquivos_WS02_HFSS/SMA_edge_connector.a3dcomp", trace_thickness=0.7mil, pcb_thickness=0.03in, pin_dia=0.03in, pin_length=0.15in, gnd_pin_length=0.15in)
  conn_center_pin_1 [perfect conductor] = part_of(SMA_edge_connector6)
  conn_diel_1 [Teflon (tm) lossless] = part_of(SMA_edge_connector6)
  conn_shell_1 [perfect conductor] = part_of(SMA_edge_connector6)
boundaries and excitations:
  PerfE_ground: Perfect E Faces=substrate.face(#189)
  PerfE_left_gnd: Perfect E Objects=gnd_pad_left
  Rad1: Radiation Faces=Region.face(all 6)
  Sym1: Symmetry Faces=Region.face(+y) IsPerfectE=false
  MS: Wave Port Objects=Port_Wave NumModes=1 Modes{Mode1{CharImp=Zpi RenormImp=50ohm}}
  SMA_edge_connector_half1_1: Wave Port Faces=conn_diel.face(#3792) NumModes=1 Modes{Mode1{IntLine{(0.37480315, -0.08375, 0.0157) -> (0.37480315, -0.025, 0.0157)} CharImp=Zpi RenormImp=50ohm}}
  SMA_edge_connector6_1: Wave Port Faces=conn_diel_1.face(#4044) NumModes=1 Modes{Mode1{IntLine{(0.37480315, 0, 0.09945) -> (0.37480315, 0, 0.0407)} CharImp=Zpi RenormImp=50ohm}}
mesh:
  initial mesh: MeshMethod=AnsoftClassic
setups:
  Setup1: HfssDriven Frequency=5GHz MaxDeltaS=0.002 MaximumPasses=12 MinimumPasses=1 MinimumConvergedPasses=1 PercentRefinement=30 BasisOrder=1 PortAccuracy=0.5 DrivenSolverType="Direct Solver"
    sweep Sweep: 0.1GHz to 12GHz, 401 points; Type=Interpolating InterpTolerance=0.5 InterpMaxSolns=250 InterpUsePortImped=false PassivityErrorTolerance=0.0001
    sweep Sweep1: point 12GHz; SaveSingleField Type=Discrete
source amplitudes:
  MS:1: 1W 0deg
  SMA_edge_connector_half1_1:1, SMA_edge_connector6_1:1: 0W 0deg
field plots:
  Mag_E1: E Field over a plane on Setup1 : Sweep1 at Freq=12GHz Phase=0deg
reports:
  S Parameter Plot 1: dB(S(MS,SMA_edge_connector6_1)), dB(S(SMA_edge_connector6_1,SMA_edge_connector6_1)) vs Freq on Setup1 : Sweep
  S Parameter Plot 2: dB(S(SMA_edge_connector6_1,SMA_edge_connector6_1)) vs Freq on Setup1 : AdaptivePass [Pass=all]
