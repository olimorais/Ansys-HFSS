# Ansys Electronics Desktop project, version 2018.2
materials:
  vacuum: permittivity=1
  FR4_epoxy: permittivity=4.4 dielectric_loss_tangent=0.02
  copper: permeability=0.999991 conductivity=58000000

design Microstrip_Bend (HFSS, DrivenTerminal, model units mm)
variables:
  Substrate_thickness = 1mm
  Trace_width = 2mm
  Trace_thick = 0.2mm
geometry:
  Substrate [FR4_epoxy] = box(corner=(-10mm, 10mm, 0mm), size=(20mm, 20mm, Substrate_thickness))
  GND [FR4_epoxy] = object_from(Substrate.face(-z))
  coordinate_system FaceCS1 = face of Substrate: Origin=centre of Substrate.face(+z) FaceID=Substrate.face(+z) AxisPosn=middle of Substrate.edge(1 of 12) WhichAxis=X
  Trace [copper] = polyline(z=0mm, xy in mm: (10, 0) (0, 0) (0, 10), section line width=Trace_width) in FaceCS1
  port1 = object_from(Trace.edge(at (10, 20, 1)))
  Substrate_ObjectFromEdge1 = object_from(Substrate.edge(12 of 12))
  port1.sweep_along_path(Substrate_ObjectFromEdge1)
  port2 = object_from(Trace.edge(at (0, 30, 1)))
  Substrate_ObjectFromEdge2 = object_from(Substrate.edge(12 of 12))
  port2.sweep_along_path(Substrate_ObjectFromEdge2)
  Trace.thicken(Trace_thick)
  RadiatingSurface [vacuum] = region(absolute_offset=10mm on all sides) in FaceCS1
boundaries and excitations:
  PerfE1: Perfect E Faces=GND.face
  Open1: Radiation Objects=RadiatingSurface
  Trace_T1: Terminal port=1 Edges=Trace.edge(at (10, 20, 1)) TerminalResistance=50ohm
  Trace_T2: Terminal port=2 Edges=Trace.edge(at (0, 30, 1)) TerminalResistance=50ohm
  1: Lumped Port Faces=port1.face Impedance=50ohm
  2: Lumped Port Faces=port2.face Impedance=50ohm
  reference conductors: GND
setups:
  Setup1: HfssDriven Frequency=10GHz MaxDeltaS=0.02 MaximumPasses=6 MinimumPasses=1 MinimumConvergedPasses=1 PercentRefinement=30 BasisOrder=1 PortAccuracy=2
    sweep Sweep: 0GHz to 10GHz step 0.1GHz; Type=Interpolating InterpTolerance=0.5 InterpMaxSolns=250 MinSolvedFreq=0.01GHz PassivityErrorTolerance=0.0001
  Setup2: HfssDriven Frequency=10GHz MaxDeltaS=0.02 MaximumPasses=1 MinimumPasses=1 MinimumConvergedPasses=1 PercentRefinement=30 MeshLink{LinkID=240 Project="This Project*" Design="This Design*" Params{Substrate_thickness=Substrate_thickness Trace_thick=Trace_thick Trace_width=Trace_width} PathRelativeTo=TargetProject} BasisOrder=1 DoLambdaRefine=false PortAccuracy=2 VariablesForDerivatives(Substrate_thickness, Trace_thick, Trace_width) VariableFlagsForDerivatives(1, 1, 1)
    sweep Sweep: 0GHz to 10GHz step 0.1GHz; Type=Interpolating InterpTolerance=0.5 InterpMaxSolns=250 MinSolvedFreq=0.01GHz PassivityErrorTolerance=0.0001
source amplitudes:
  1:1: 1V 0deg
  2:1: 0V 0deg
optimetrics:
  ParametricSetup1: Parametric Sim._Setups=[Setup1, Setup2]
    sweep Substrate_thickness: LIN 0.5mm 1.5mm 0.25mm (synchronised group 1)
    sweep Trace_width: LIN 1mm 3mm 0.5mm (synchronised group 1)
    sweep Trace_thick: LIN 0.16mm 0.24mm 0.02mm (synchronised group 1)
radiation setups:
  3D: Infinite Sphere Theta=0deg..180deg step 2deg Phi=-180deg..180deg step 2deg CoordSystem=FaceCS1
  Elevation: Infinite Sphere Theta=-180deg..180deg step 1deg Phi=0deg..90deg step 90deg CoordSystem=FaceCS1
  Azimuth: Infinite Sphere Theta=90deg..90deg step 0deg Phi=-180deg..180deg step 1deg CoordSystem=FaceCS1
reports:
  Terminal S Parameter Plot 1: dB(St(Trace_T1,Trace_T2)) vs Freq on Setup1 : Sweep [Substrate_thickness=all Trace_width=all Trace_thick=all]
  Terminal S Parameter Plot 2: dB(St(Trace_T1,Trace_T2)) vs Freq on Setup1 : Sweep [Substrate_thickness=all Trace_width=all Trace_thick=all]
   Plot 1: dB(St(Trace_T1,Trace_T2)) vs Freq on Setup2 : Sweep [Substrate_thickness=all Trace_width=all Trace_thick=all]
